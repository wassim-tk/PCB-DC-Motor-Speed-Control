* C:\Users\wassim Toukebri\OneDrive - Ministere de l'Enseignement Superieur et de la Recherche Scientifique\Desktop\1AGE3\S2\mini projet electronique\simulation\variateur_WASSIM\variateur\charge_condensateur.sch

* Schematics Version 9.2
* Mon May 11 21:23:23 2026

** Analysis setup **
.tran 0ms 2ms 1.5ms 0.5us
.OP

* From [PSPICE NETLIST] section of C:\Program Files\Orcad\PSpice\PSpice.ini:
.lib "nom.lib"

.INC "charge_condensateur.net"

.PROBE V(*) I(*) W(*) D(*) NOISE(*)

.END
