* D:\ENIT 1\mini projet\variateur-\variateur\transistor de augumentation du courant.sch

* Schematics Version 9.2
* Sat Apr 25 20:10:30 2026

** Analysis setup **
.tran 0ns 30ms 0 1ms
.OP

* From [PSPICE NETLIST] section of C:\Program Files\Orcad\PSpice\PSpice.ini:
.lib "nom.lib"

.INC "transistor de augumentation du courant.net"

.PROBE V(*) I(*) W(*) D(*) NOISE(*)

.END
