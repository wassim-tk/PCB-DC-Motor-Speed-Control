* C:\Users\win10\Desktop\Ayoub\Mini_Projet_Electronique\varaiteur de vitesse\variateur_de_vitesse_spice\variateur\marche_arret.sch

* Schematics Version 9.2
* Sat Mar 21 10:46:16 2026

** Analysis setup **
.tran 0ns 200ms SKIPBP
.OP

* From [PSPICE NETLIST] section of C:\Program Files\Orcad\PSpice\PSpice.ini:
.lib "nom.lib"

.INC "marche_arret.net"

.PROBE V(*) I(*) W(*) D(*) NOISE(*)

.END
