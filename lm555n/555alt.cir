* C:\Users\wassim Toukebri\OneDrive - Ministere de l'Enseignement Superieur et de la Recherche Scientifique\Desktop\1AGE3\S2\mini projet electronique\lm555n\555alt.sch

* Schematics Version 9.2
* Tue Jan 27 13:25:44 2026

** Analysis setup **
.tran 0ns 200ms
.OP

* From [PSPICE NETLIST] section of C:\Program Files\Orcad\PSpice\PSpice.ini:
.lib "nom.lib"

.INC "555alt.net"

.PROBE V(*) I(*) W(*) D(*) NOISE(*)

.END
